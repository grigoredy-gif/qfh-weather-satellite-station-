* RX2 L2 - the whole receiver with FM: antenna to detector output
* Tests: a 137.9 MHz carrier, FM +-17 kHz at 2400 Hz, on a 50 ohm antenna. Both crystal currents are forced
*   (25 MHz at 1.68 mA, 14.31818 MHz at 1.3 mA), so the LOs are the real waveforms at the exact frequencies.
*   Levels (available at the antenna): run=1 is 0.2 uV, run=2 is 2 uV, run=3 is 10 mV rms (-121, -101, -27 dBm).
*   One level per run (set "run" below): a run takes from 10 minutes (strong signal) to over an hour (weak).
*   The first 0.167 ms are not saved; LTspice then counts time from 0, so the saved window is 0 to 0.833 ms,
*   exactly two cycles of 2400 Hz. The DC level is still settling a little in that window, which LTspice counts
*   as distortion; the design log gives the figures with that drift removed.
*   The harmonic table of V(det) gives the 2400 Hz audio (line 1) and its distortion.
*   There is no noise in this kind of run: it shows gain, limiting and distortion, not sensitivity.
.include models.lib
.param VCC=3.3 tolL=0 tolC=0 tolLr=0 tolS=0 xforce=1 pkg=0 voq=0 sd=0
.param run=2
.param AIN=table(run,1,0.566u,2,5.66u,3,28.3m)
Vcc vcc 0 {VCC}
Vs src 0 SFFM(0 {AIN} 137.9Meg 7.0833 2400)
Rs src ant 50
Ixf o25b osc25 SINE(0 1.68m 25Meg)
Ixf2 ob xs2 SINE(0 1.3m 14.31818Meg)
.include rx2_blk_bias.inc
.include rx2_blk_fe.inc
.include rx2_blk_mix1.inc
.include rx2_blk_lo1osc.inc
.include rx2_blk_lo1mul.inc
.include rx2_blk_if1.inc
.include rx2_blk_mix2.inc
.include rx2_blk_lo2.inc
.include rx2_blk_if2.inc
.options plotwinsize=0 method=gear
.tran 0 1m 0.1666667m 100p
.save V(det) V(m2in)
.four 2400 9 2 V(det)
.meas TRAN vdet_dc AVG V(det)
.meas TRAN m2in_pp PP V(m2in)
.end
