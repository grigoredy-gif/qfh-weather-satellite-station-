* RX2 H1 - back half with an FM signal: second mixer + second-IF strip + detector
* Tests: FM at 12.9 MHz (+-17 kHz, 2400 Hz tone) into the second mixer, audio out of the detector, against input level.
*   LO2 is an ideal 14.31818 MHz source at the level the crystal oscillator delivers (0.18 V peak), so the frequency is exact.
.include models.lib
.param VCC=3.3 tolL=0 tolC=0 sd=0
* input at the mixer, peak:  0.1 mV   0.3 mV   1 mV   10 mV
.step param run 1 4 1
.param A=table(run,1,0.1m,2,0.3m,3,1m,4,10m)
Vcc vcc 0 {VCC}
Vin m2in 0 SFFM(0 {A} 12.9Meg 7.0833 2400)
Vlo lo2s 0 SINE(0 0.18 14.31818Meg)
Clo2s lo2s lo2 1n
.include rx2_blk_mix2.inc
.include rx2_blk_bias.inc
.include rx2_blk_if2.inc
.options plotwinsize=0
.tran 0 3m 0 2n
.four 2400 9 4 V(det)
.meas TRAN vdet_dc AVG V(det) from 1.3333m to 3m
.meas TRAN t5_pp PP V(t5) from 2.99m to 3m
.meas TRAN t6_pp PP V(t6) from 2.99m to 3m
.meas TRAN cb_pp PP V(cb) from 2.99m to 3m
.meas TRAN c2_pp PP V(c2) from 2.99m to 3m
.meas TRAN icc AVG -I(Vcc) from 2m to 3m
.end
