* RX2 E1 - second mixer: conversion gain and LO leakage against LO drive
* Tests: 1 mV at 12.9 MHz in, LO 14.3 MHz, output at 1.4 MHz on T5 (frequencies rounded so one 10 us window holds whole cycles of all three).
*   four[..] V(t5) at 1.4 MHz / 1 mV = conversion gain.  V(t5) and V(ba1) at 14.3 MHz = LO leaking into the second IF.
.include models.lib
.param VCC=3.3 tolL=0 tolC=0 sd=0
.step param ALO list 0.05 0.1 0.18 0.3
Vcc vcc 0 {VCC}
Vin m2in 0 SINE(0 1m 12.9Meg)
Vlo lo2s 0 SINE(0 {ALO} 14.3Meg)
Clo2s lo2s lo2 1n
.include rx2_blk_mix2.inc
.include rx2_blk_bias.inc
.include rx2_blk_if2.inc
.options plotwinsize=0 method=gear
.tran 0 60u 0 1n
.four 1.4Meg 2 14 V(t5)
.four 14.3Meg 2 143 V(t5)
.four 14.3Meg 2 143 V(ba1)
.four 1.4Meg 2 14 V(t6)
.meas TRAN it_m AVG I(Rt) from 40u to 60u
.meas TRAN vem AVG V(em1) from 40u to 60u
.end
