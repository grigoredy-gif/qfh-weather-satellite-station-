* RX2 F3 - second-IF strip, part tolerance (Monte-Carlo)
* Tests: 300 runs with every tuned-circuit inductor and capacitor drawn at random inside +-5 %, nothing trimmed.
*   t6_at = response at the signal frequency 1.41818 MHz (nominal is about -15.3 dB re 1 V per uA);
*   t6_fpk = where the two tuned circuits peak; t6_flo / t6_fhi = their -3 dB edges.
.include models.lib
.param VCC=3.3 tolL=0.05 tolC=0.05
.step param mcrun 1 302 1
* runs 301 and 302: every part at the bottom, then at the top of its tolerance (all off the same way)
.param sd=if(mcrun>301,1,if(mcrun>300,-1,0))
Vcc vcc 0 {VCC}
I1 0 t5 AC 1u
* the second mixer is connected (no signal, no LO): its collectors load T5 and move its centre
Vin m2in 0 0
Vlo lo2s 0 0
Clo2s lo2s lo2 1n
.include rx2_blk_mix2.inc
.include rx2_blk_bias.inc
.include rx2_blk_if2.inc
.ac lin 1801 1.0Meg 1.9Meg
.meas AC t6_pk MAX mag(V(t6))
.meas AC t6_fpk WHEN mag(V(t6))=t6_pk
.meas AC t6_flo WHEN mag(V(t6))=t6_pk/sqrt(2) RISE=1
.meas AC t6_fhi WHEN mag(V(t6))=t6_pk/sqrt(2) FALL=last
.meas AC t6_at FIND mag(V(t6)) AT 1.41818Meg
.meas AC t6_lo FIND mag(V(t6)) AT 1.39718Meg
.meas AC t6_hi FIND mag(V(t6)) AT 1.43918Meg
.end
