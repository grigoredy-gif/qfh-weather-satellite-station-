* RX2 A2 - front end, part tolerance (Monte-Carlo)
* Tests: 300 runs. Inductors +-2 %, capacitors of 10 pF and more +-5 %, smaller capacitors +-0.25 pF. Nothing trimmed.
*   g_1379 / g_1371 = response at the two satellite channels (nominal about 13.2 dB re 1 V source = +19.2 dB of gain);
*   rej_img = 137.9 MHz response over the response at the image 112.1 MHz; s11 = reflection at the connector.
.include models.lib
.param VCC=3.3 tolL=0 tolC=0.05 tolLr=0.02 tolS=1 pkg=0
.step param mcrun 1 302 1
* runs 301 and 302: every part at the bottom, then at the top of its tolerance (all off the same way)
.param sd=if(mcrun>301,1,if(mcrun>300,-1,0))
Vcc vcc 0 {VCC}
Vs src 0 AC 1
Rs src ant 50
Vlo1 lo1 0 0
Rt1 t1 vcc 1k
.include rx2_blk_bias.inc
.include rx2_blk_fe.inc
.include rx2_blk_mix1.inc
.ac lin 1101 80Meg 190Meg
.meas AC g_pk MAX mag(V(m1in))
.meas AC g_fpk WHEN mag(V(m1in))=g_pk
.meas AC g_1379 FIND mag(V(m1in)) AT 137.9Meg
.meas AC g_1371 FIND mag(V(m1in)) AT 137.1Meg
.meas AC g_img FIND mag(V(m1in)) AT 112.1Meg
.meas AC rej_img PARAM g_1379/g_img
.meas AC s11 FIND mag(2*V(ant)-1) AT 137.9Meg
.end
