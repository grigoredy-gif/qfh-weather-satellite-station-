* RX2 F2 - second-IF strip with an FM signal
* Tests: limiting threshold, audio level and distortion against input level (input: FM current into T5, as from mixer 2).
*   Signal: 1.41818 MHz, +-17 kHz deviation, 2400 Hz tone. V(det) is the detector output.
.include models.lib
.param VCC=3.3 tolL=0 tolC=0 FC=1.41818Meg MI=7.0833 sd=0
* input current, peak:   0.03 uA  0.1 uA  0.3 uA  1 uA  10 uA  100 uA   (x 6.5 kohm = voltage on T5)
.step param run 1 6 1
.param IPK=table(run,1,0.03u,2,0.1u,3,0.3u,4,1u,5,10u,6,100u)
Vcc vcc 0 {VCC}
I1 0 t5 SFFM(0 {IPK} {FC} {MI} 2400)
* the second mixer is connected (no signal, no LO): its collectors load T5 and move its centre
Vin m2in 0 0
Vlo lo2s 0 0
Clo2s lo2s lo2 1n
.include rx2_blk_mix2.inc
.include rx2_blk_bias.inc
.include rx2_blk_if2.inc
.options plotwinsize=0
.tran 0 3m 0 4n
.four 2400 9 4 V(det)
.meas TRAN vdet_dc AVG V(det) from 1.3333m to 3m
.meas TRAN t5_pp PP V(t5) from 2.99m to 3m
.meas TRAN t6_pp PP V(t6) from 2.99m to 3m
.meas TRAN cb_pp PP V(cb) from 2.99m to 3m
.meas TRAN c2_pp PP V(c2) from 2.99m to 3m
.end
