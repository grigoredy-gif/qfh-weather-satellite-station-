* SIM 4b rev 2 - CASCODE IF chain + limiter: DOES IT ACTUALLY LIMIT? (.tran)
* ---------------------------------------------------------------------------
* Same circuit as sim4a rev 2 (see there for why the stages are cascodes).
* This question cannot be answered by an .ac run: limiting is a large-signal
* effect. A limiter's whole job is to make the OUTPUT AMPLITUDE INDEPENDENT
* OF THE INPUT LEVEL, so the slope detector sees a constant carrier and
* converts only frequency - fading and AM noise get thrown away instead of
* turning into fake picture content. So the input is stepped over 54 dB and
* we watch the output refuse to follow.
*
* Expected with ~75 dB of gain and clipping at ~1.2 V:
*   20 uV  -> ~0.1 V   (linear, below the diodes)
*   100 uV -> ~0.5 V   (still linear)
*   1 mV   -> ~1.2 V   (limiting)
*   10 mV  -> ~1.2 V   (hard limiting, stages saturating too)
* The last two being nearly equal IS the pass criterion.
*
* The run starts from the DC operating point (no uic), so the 100 nF
* bypasses and 1 nF couplers are pre-charged and only the RF has to settle -
* a few us through three tanks. The two spaced measurement windows PROVE
* that instead of assuming it: standing rule from SIM 5b, the slowest loop
* sets the measurement window.
*
* PASS: Voutpp at 1 mV and 10 mV within ~1 dB of each other and >= 2 Vpp;
* Voutpp_mid == Voutpp (settled); emitter DC voltages steady across the input
* range - a stage whose emitter DC shifts under overdrive is rectifying, not
* amplifying, and would need more degeneration or less drive.
* ---------------------------------------------------------------------------

VCC vcc 0 6
Cbyp vcc 0 100n

Rc2a vcc vb2 22k
Rc2b vb2 0 18k
Cb2 vb2 0 100n

V1 src 0 SINE(0 {A} 12.9Meg)
RS src sin 1k
Cin sin b1 1n

* ---------------- stage 1 ----------------
RB1 vcc b1 47k
RB2 b1 0 13k
Q1a c1a b1 e1 QRF
RE1 e1 e1b 180
RE2 e1b 0 330
CE1 e1b 0 100n
Q1b c1 vb2 c1a QRF
Lb1 c1 t1 0.588u
La1 t1 vcc 0.507u
K1 La1 Lb1 0.999
Ct1 c1 0 68p
Rd1 c1 0 10k

* ---------------- stage 2 ----------------
Cc1 t1 b2 1n
RB3 vcc b2 47k
RB4 b2 0 13k
Q2a c2a b2 e2 QRF
RE3 e2 e2b 180
RE4 e2b 0 330
CE2 e2b 0 100n
Q2b c2 vb2 c2a QRF
Lb2 c2 t2 0.588u
La2 t2 vcc 0.507u
K2 La2 Lb2 0.999
Ct2 c2 0 68p
Rd2 c2 0 10k

* ---------------- stage 3 ----------------
Cc2 t2 b3 1n
RB5 vcc b3 47k
RB6 b3 0 13k
Q3a c3a b3 e3 QRF
RE5 e3 e3b 180
RE6 e3b 0 330
CE3 e3b 0 100n
Q3b c3 vb2 c3a QRF
L3 c3 vcc 2.2u
Ct3 c3 0 68p
Rd3 c3 0 10k

* ---------------- limiter + output ----------------
Cc3 c3 out 1n
Rout out 0 100k
D1 out n1 DX
D2 n1 0 DX
D3 0 n2 DX
D4 n2 out DX

* ---------------- models ----------------
.model QRF NPN(IS=1f BF=100 VAF=60 IKF=0.08 RB=10 RE=0.6 RC=5 CJE=1.1p
+ VJE=0.7 MJE=0.33 CJC=0.7p VJC=0.55 MJC=0.33 XCJC=0.6 TF=28p XTF=2
+ VTF=4 ITF=0.05 TR=0.5n)
.model DX D(Is=2.52n Rs=0.568 N=1.752 Cjo=4p M=0.333 Vj=0.7 Bv=100
+ Ibv=1u Tt=11.5n)

* ---------------- analysis ----------------
.step param A list 20u 100u 1m 10m
.tran 0 30u 0 1n
.options plotwinsize=0
.four 12.9Meg 5 4 V(out)
.meas TRAN Voutpp PP V(out) FROM 25u TO 30u
.meas TRAN Voutpp_mid PP V(out) FROM 21u TO 26u
.meas TRAN Vc3pp PP V(c3) FROM 25u TO 30u
.meas TRAN Vb3pp PP V(b3) FROM 25u TO 30u
.meas TRAN Vc1pp PP V(c1) FROM 25u TO 30u
.meas TRAN Ve1dc AVG V(e1) FROM 25u TO 30u
.meas TRAN Ve2dc AVG V(e2) FROM 25u TO 30u
.meas TRAN Ve3dc AVG V(e3) FROM 25u TO 30u
.meas TRAN Vc1adc AVG V(c1a) FROM 25u TO 30u
.end
