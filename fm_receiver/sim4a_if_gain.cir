* SIM 4a rev 2 - CASCODE IF amplifier chain: gain, bandwidth, stability margin
* ---------------------------------------------------------------------------
* WHY REV 2 EXISTS. Rev 1 used three single-transistor tuned common-emitter
* stages. It "worked" - 87 dB at 12.9 MHz - but the measurements gave it away:
*   - the base voltage rose ABOVE the source voltage (+10 dB), which a passive
*     network cannot do: energy was coming back from the collector;
*   - the -3 dB bandwidth collapsed to 51 kHz against a natural ~200 kHz,
*     i.e. a Q-multiplication of 4, i.e. a feedback loop gain of ~0.75;
*   - a 1.5 % change in one capacitor moved the bandwidth by 2.5x.
* That is an amplifier three quarters of the way to oscillation, in a
* simulation that has no board capacitance and no coil-to-coil coupling.
* The real board would supply the rest. The culprit is Miller feedback
* through the transistor's 0.7 pF base-collector capacitance, multiplied by
* the ~33x voltage gain at the collector.
*
* THE FIX: CASCODE. Each stage becomes two transistors. The lower one
* (common emitter) drives the emitter of the upper one (common base), which
* is an impedance of only 1/gm ~ 26 ohm. So the lower transistor's collector
* barely moves: its voltage gain is ~1 instead of ~33, and its Miller
* capacitance is 0.7p x 2 = 1.4 pF instead of 23 pF. The upper transistor has
* voltage gain but its base is grounded for signal, so its collector-base
* capacitance feeds a bypassed bias node, not the input. Feedback drops ~16x.
*
* This is exactly what a BF998 dual-gate MOSFET is - two devices stacked in
* one package, gate 2 being the upper base - so the topology maps directly if
* you prefer that part on the board. It is built here from the transistors
* already in the BOM and the SAME QRF model used everywhere else in this
* project, so the improvement comes from topology, not from a hand-written
* model with a flattering number in it.
*
* WHAT CHANGES NUMERICALLY: transconductance is still set by the lower
* transistor, gm_eff = 1/(re + 180) = 4.81 mS, so the gain per stage is
* unchanged at ~25 dB. The tank strays drop from the measured 4.6 pF (rev 1,
* Miller-dominated) to ~1.5 pF, so the tuning capacitor goes back up to 68 pF.
* Headroom on 6 V: lower emitter 0.48 V, lower Vce 1.5 V, upper emitter
* 1.98 V, upper Vce 4.0 V, and the tank can swing +/-3.8 V before either
* device saturates - more than the ~1.5 V the limiter needs.
*
* PASS: peak within ~100 kHz of 12.9 MHz; gain 70-85 dB; -3 dB bandwidth
* 120-250 kHz; and the stability tell-tales fixed - Vb1 BELOW 0 dB, and the
* bandwidth close to the ~160 kHz the loading alone predicts (no
* Q-multiplication).
* ---------------------------------------------------------------------------

VCC vcc 0 6
Cbyp vcc 0 100n

* --- shared cascode base bias (~2.7 V), one divider for all three stages ---
Rc2a vcc vb2 22k
Rc2b vb2 0 18k
Cb2 vb2 0 100n

* --- source: SIM 3's output tap looks like ~1k, AC-coupled so the bias of
* --- stage 1 is not shunted by it (a rev-1 bug worth remembering)
V1 src 0 AC 1
RS src sin 1k
Cin sin b1 1n

* ---------------- stage 1 ----------------
RB1 vcc b1 47k
RB2 b1 0 13k
Q1a c1a b1 e1 QRF
RE1 e1 e1b 180
RE2 e1b 0 330
CE1 e1b 0 100n
Q1b c1 vb2 c1a QRF
Lb1 c1 t1 0.588u
La1 t1 vcc 0.507u
K1 La1 Lb1 0.999
Ct1 c1 0 68p
Rd1 c1 0 10k

* ---------------- stage 2 ----------------
Cc1 t1 b2 1n
RB3 vcc b2 47k
RB4 b2 0 13k
Q2a c2a b2 e2 QRF
RE3 e2 e2b 180
RE4 e2b 0 330
CE2 e2b 0 100n
Q2b c2 vb2 c2a QRF
Lb2 c2 t2 0.588u
La2 t2 vcc 0.507u
K2 La2 Lb2 0.999
Ct2 c2 0 68p
Rd2 c2 0 10k

* ---------------- stage 3 (full tank, no tap) ----------------
Cc2 t2 b3 1n
RB5 vcc b3 47k
RB6 b3 0 13k
Q3a c3a b3 e3 QRF
RE5 e3 e3b 180
RE6 e3b 0 330
CE3 e3b 0 100n
Q3b c3 vb2 c3a QRF
L3 c3 vcc 2.2u
Ct3 c3 0 68p
Rd3 c3 0 10k

* ---------------- limiter + output ----------------
Cc3 c3 out 1n
Rout out 0 100k
D1 out n1 DX
D2 n1 0 DX
D3 0 n2 DX
D4 n2 out DX

* ---------------- models ----------------
.model QRF NPN(IS=1f BF=100 VAF=60 IKF=0.08 RB=10 RE=0.6 RC=5 CJE=1.1p
+ VJE=0.7 MJE=0.33 CJC=0.7p VJC=0.55 MJC=0.33 XCJC=0.6 TF=28p XTF=2
+ VTF=4 ITF=0.05 TR=0.5n)
.model DX D(Is=2.52n Rs=0.568 N=1.752 Cjo=4p M=0.333 Vj=0.7 Bv=100
+ Ibv=1u Tt=11.5n)

* ---------------- analysis ----------------
.ac dec 400 8Meg 20Meg
.options plotwinsize=0
.meas AC Gpk MAX mag(V(out))
.meas AC BW trig mag(V(out))=Gpk/sqrt(2) rise=1 targ mag(V(out))=Gpk/sqrt(2) fall=last
.meas AC Vb1 FIND mag(V(b1)) AT 12.9Meg
.meas AC S1 FIND mag(V(t1)) AT 12.9Meg
.meas AC S2 FIND mag(V(t2)) AT 12.9Meg
.meas AC S3 FIND mag(V(c3)) AT 12.9Meg
.meas AC Gout FIND mag(V(out)) AT 12.9Meg
.meas AC Grej500 FIND mag(V(out)) AT 12.4Meg
.meas AC Grej1M FIND mag(V(out)) AT 11.9Meg
.end
