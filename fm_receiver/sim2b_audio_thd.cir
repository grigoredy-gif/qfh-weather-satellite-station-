* SIM 2b - audio LPF + scaling chain: LEVELS, BIAS AND DISTORTION (.tran)
* ---------------------------------------------------------------------------
* Identical circuit to sim2a (see there for the full chain description).
* Drive: the real SIM-1 detector output - 60 mVpp of 2400 Hz on a 0.23 V
* pedestal, behind 150k. The .tran starts from the DC operating point
* (no uic), so the big coupling/bypass caps are pre-charged and the run
* needs only 20 ms.
*
* PASS:
*   Vadcavg  ~ 1.65 V  (ADC mid-scale bias correct)
*   Vadcpp   ~ 1.2-1.6 Vpp (fills a healthy fraction of the 3.3 V range)
*   THD at 2400 Hz < 5 % (expect 2-4 %, dominated by the CE stage's re
*   modulation - if it fails, raise the stage current / degeneration)
*   Vcedc    ~ 2.4-2.6 V (gain stage biased mid-supply)
* ---------------------------------------------------------------------------

* --- supplies ---
VCC vcc 0 6
VREF adcref 0 3.3

* --- detector equivalent ---
V1 src 0 SINE(0.23 0.03 2400)
RS src in 150k

* --- PNP Darlington follower ---
Q1a 0 in b1 QP
Q1b 0 b1 ef1 QP
RE1 vcc ef1 10k

* --- Sallen-Key stage 1 (NPN), Q=0.55 ---
RA1 ef1 x1 10k
RB1 x1 y1 10k
C1 x1 ef2 3.3n
C2 y1 0 2.7n
Q2 vcc y1 ef2 QN
RE2 ef2 0 4.7k

* --- Sallen-Key stage 2 (PNP), Q=1.29 ---
RA2 ef2 x2 7.5k
RB2 x2 y2 7.5k
C3 x2 ef3 10n
C4 y2 0 1.5n
Q3 0 y2 ef3 QP
RE3 vcc ef3 10k

* --- common-emitter gain stage ---
RB4 ef3 y4 1k
Q4 ce y4 e4 QN
RC4 vcc ce 10k
RE4A e4 e4b 150
RE4B e4b 0 2.7k
CE4 e4b 0 100u

* --- AC coupling + ADC bias ---
CC1 ce adc 1u
RD1 adcref adc 47k
RD2 adc 0 47k
CADC adc 0 470p

* --- models ---
.model QN NPN(IS=1e-14 BF=200 VAF=100 CJE=8p CJC=4p TF=350p RB=10)
.model QP PNP(IS=1e-14 BF=200 VAF=100 CJE=10p CJC=6p TF=400p RB=10)

* --- analysis ---
.options plotwinsize=0
.tran 0 20m 0 1u
.four 2400 9 8 V(adc)
.meas TRAN Vadcpp PP V(adc) FROM 10m TO 20m
.meas TRAN Vadcavg AVG V(adc) FROM 10m TO 20m
.meas TRAN Vcedc AVG V(ce) FROM 10m TO 20m
.meas TRAN Vef1dc AVG V(ef1) FROM 10m TO 20m
.end
